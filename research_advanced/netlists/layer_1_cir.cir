* OpenAnalogNN Auto-Generated ngspice Netlist: layer_1_cir
* Ideal Op-Amp model with saturation limit
.subckt opamp_sat IN+ IN- OUT GND
B1 OUT GND V=limit(1e5*(V(IN+)-V(IN-)), -2.5, 2.5)
.ends opamp_sat

* Circuit Components
V_in_0 node_in_0 0 0.0
V_in_1 node_in_1 0 1.0138636827468872
V_in_2 node_in_2 0 0.0
V_in_3 node_in_3 0 0.0
V_in_4 node_in_4 0 0.0
V_in_5 node_in_5 0 0.0
V_in_6 node_in_6 0 1.4969122409820557
V_in_7 node_in_7 0 0.2370414286851883
V_in_8 node_in_8 0 0.33058616518974304
V_in_9 node_in_9 0 0.0
V_in_10 node_in_10 0 0.8440532684326172
V_in_11 node_in_11 0 1.3814164400100708
V_in_12 node_in_12 0 0.0
V_in_13 node_in_13 0 0.0
V_in_14 node_in_14 0 0.5084373354911804
V_in_15 node_in_15 0 0.898236095905304
V_in_16 node_in_16 0 0.0
V_in_17 node_in_17 0 0.16873902082443237
V_in_18 node_in_18 0 0.0
V_in_19 node_in_19 0 0.0
V_in_20 node_in_20 0 0.0
V_in_21 node_in_21 0 0.0
V_in_22 node_in_22 0 0.1924091875553131
V_in_23 node_in_23 0 0.029252760112285614
V_in_24 node_in_24 0 0.0
V_in_25 node_in_25 0 0.0
V_in_26 node_in_26 0 0.43373095989227295
V_in_27 node_in_27 0 0.0035858750343322754
V_in_28 node_in_28 0 1.1232308149337769
V_in_29 node_in_29 0 0.0
V_in_30 node_in_30 0 0.0
V_in_31 node_in_31 0 0.2997538447380066
V_bias node_bias 0 1.0
X_opamp_pos_0 0 node_sum_pos_0 node_out_pos_0 0 opamp_sat
R_rf_pos_0 node_sum_pos_0 node_out_pos_0 10000.0
X_opamp_neg_0 0 node_sum_neg_0 node_out_neg_0 0 opamp_sat
R_rf_neg_0 node_sum_neg_0 node_out_neg_0 10000.0
R_rw_pos_0_0 node_in_0 node_sum_pos_0 145602.15679693266
R_rw_pos_0_1 node_in_1 node_sum_pos_0 50619.97812992862
R_rw_pos_0_2 node_in_2 node_sum_pos_0 32737.401399531747
R_rw_pos_0_3 node_in_3 node_sum_pos_0 29529.865667858852
R_rw_pos_0_4 node_in_4 node_sum_pos_0 243017.87611237966
R_rw_pos_0_5 node_in_5 node_sum_pos_0 96634.2516694566
R_rw_neg_0_6 node_in_6 node_sum_neg_0 76928.82020647444
R_rw_pos_0_7 node_in_7 node_sum_pos_0 43069.69476155569
R_rw_pos_0_8 node_in_8 node_sum_pos_0 72078.31805388899
R_rw_pos_0_9 node_in_9 node_sum_pos_0 51795.282991417705
R_rw_neg_0_10 node_in_10 node_sum_neg_0 72053.02745942157
R_rw_neg_0_11 node_in_11 node_sum_neg_0 71171.48917965066
R_rw_pos_0_12 node_in_12 node_sum_pos_0 113534.31836299386
R_rw_pos_0_13 node_in_13 node_sum_pos_0 51372.77245962469
R_rw_pos_0_14 node_in_14 node_sum_pos_0 44006.204907794585
R_rw_pos_0_15 node_in_15 node_sum_pos_0 26625.013876108234
R_rw_neg_0_16 node_in_16 node_sum_neg_0 175721.99895471003
R_rw_pos_0_17 node_in_17 node_sum_pos_0 87222.3966367535
R_rw_neg_0_18 node_in_18 node_sum_neg_0 114856.34755081937
R_rw_pos_0_19 node_in_19 node_sum_pos_0 311615.55619918706
R_rw_neg_0_20 node_in_20 node_sum_neg_0 88593.67665955392
R_rw_pos_0_21 node_in_21 node_sum_pos_0 222046.86770393414
R_rw_neg_0_22 node_in_22 node_sum_neg_0 617591.7608864354
R_rw_neg_0_23 node_in_23 node_sum_neg_0 41630.705631003395
R_rw_neg_0_24 node_in_24 node_sum_neg_0 39247.2127340208
R_rw_neg_0_25 node_in_25 node_sum_neg_0 66263.89988067161
R_rw_neg_0_26 node_in_26 node_sum_neg_0 39130.31846939148
R_rw_neg_0_27 node_in_27 node_sum_neg_0 105104.20896154235
R_rw_pos_0_28 node_in_28 node_sum_pos_0 339593.33376767876
R_rw_neg_0_29 node_in_29 node_sum_neg_0 108699.82458878303
R_rw_pos_0_30 node_in_30 node_sum_pos_0 28627.34281292229
R_rw_neg_0_31 node_in_31 node_sum_neg_0 60163.61265345298
R_rbias_neg_0 node_bias node_sum_neg_0 63506.03336455853
X_opamp_sub_0 node_sub_pos_0 node_sub_neg_0 node_out_0 0 opamp_sat
R_rsub1_0 node_out_pos_0 node_sub_neg_0 10000.0
R_rsub2_0 node_sub_neg_0 node_out_0 10000.0
R_rsub3_0 node_out_neg_0 node_sub_pos_0 10000.0
R_rsub4_0 node_sub_pos_0 0 10000.0
X_opamp_pos_1 0 node_sum_pos_1 node_out_pos_1 0 opamp_sat
R_rf_pos_1 node_sum_pos_1 node_out_pos_1 10000.0
X_opamp_neg_1 0 node_sum_neg_1 node_out_neg_1 0 opamp_sat
R_rf_neg_1 node_sum_neg_1 node_out_neg_1 10000.0
R_rw_neg_1_0 node_in_0 node_sum_neg_1 50076.46210484835
R_rw_pos_1_1 node_in_1 node_sum_pos_1 33288.377967929126
R_rw_pos_1_2 node_in_2 node_sum_pos_1 126711.45542116034
R_rw_pos_1_3 node_in_3 node_sum_pos_1 176413.5691959502
R_rw_neg_1_4 node_in_4 node_sum_neg_1 969222.8655473874
R_rw_neg_1_5 node_in_5 node_sum_neg_1 28214.24081890708
R_rw_neg_1_6 node_in_6 node_sum_neg_1 165973.87456258305
R_rw_neg_1_7 node_in_7 node_sum_neg_1 22533576.575394932
R_rw_pos_1_8 node_in_8 node_sum_pos_1 58728.485329006726
R_rw_neg_1_9 node_in_9 node_sum_neg_1 101497.20976256042
R_rw_neg_1_10 node_in_10 node_sum_neg_1 44196.547368653984
R_rw_neg_1_11 node_in_11 node_sum_neg_1 63302.67065197572
R_rw_pos_1_12 node_in_12 node_sum_pos_1 45661.849467527965
R_rw_neg_1_13 node_in_13 node_sum_neg_1 75356.58156727275
R_rw_pos_1_14 node_in_14 node_sum_pos_1 139188.13634902364
R_rw_pos_1_15 node_in_15 node_sum_pos_1 674646.4725035565
R_rw_neg_1_16 node_in_16 node_sum_neg_1 29598.70689700799
R_rw_pos_1_17 node_in_17 node_sum_pos_1 48738.05376382742
R_rw_neg_1_18 node_in_18 node_sum_neg_1 42724.04352642114
R_rw_neg_1_19 node_in_19 node_sum_neg_1 28871.12299341008
R_rw_pos_1_20 node_in_20 node_sum_pos_1 78720.92461291078
R_rw_neg_1_21 node_in_21 node_sum_neg_1 38607.29713854737
R_rw_pos_1_22 node_in_22 node_sum_pos_1 34869.75036660362
R_rw_pos_1_23 node_in_23 node_sum_pos_1 48464.36916680894
R_rw_neg_1_24 node_in_24 node_sum_neg_1 35864.565498056676
R_rw_pos_1_25 node_in_25 node_sum_pos_1 74189.64215024702
R_rw_neg_1_26 node_in_26 node_sum_neg_1 51288.62971978402
R_rw_pos_1_27 node_in_27 node_sum_pos_1 86443.62263003796
R_rw_neg_1_28 node_in_28 node_sum_neg_1 56515.45459835662
R_rw_pos_1_29 node_in_29 node_sum_pos_1 498358.7911717116
R_rw_neg_1_30 node_in_30 node_sum_neg_1 37673.8319454802
R_rw_neg_1_31 node_in_31 node_sum_neg_1 48545.480166401474
R_rbias_pos_1 node_bias node_sum_pos_1 40697.52777284876
X_opamp_sub_1 node_sub_pos_1 node_sub_neg_1 node_out_1 0 opamp_sat
R_rsub1_1 node_out_pos_1 node_sub_neg_1 10000.0
R_rsub2_1 node_sub_neg_1 node_out_1 10000.0
R_rsub3_1 node_out_neg_1 node_sub_pos_1 10000.0
R_rsub4_1 node_sub_pos_1 0 10000.0
X_opamp_pos_2 0 node_sum_pos_2 node_out_pos_2 0 opamp_sat
R_rf_pos_2 node_sum_pos_2 node_out_pos_2 10000.0
X_opamp_neg_2 0 node_sum_neg_2 node_out_neg_2 0 opamp_sat
R_rf_neg_2 node_sum_neg_2 node_out_neg_2 10000.0
R_rw_pos_2_0 node_in_0 node_sum_pos_2 50213.832540057076
R_rw_pos_2_1 node_in_1 node_sum_pos_2 214287.37266094197
R_rw_neg_2_2 node_in_2 node_sum_neg_2 394287.14031375176
R_rw_neg_2_3 node_in_3 node_sum_neg_2 65012.44034249571
R_rw_pos_2_4 node_in_4 node_sum_pos_2 129028.10162726013
R_rw_pos_2_5 node_in_5 node_sum_pos_2 27971.86343864259
R_rw_pos_2_6 node_in_6 node_sum_pos_2 36977.69784450149
R_rw_neg_2_7 node_in_7 node_sum_neg_2 389565.8837025146
R_rw_neg_2_8 node_in_8 node_sum_neg_2 70517.13334751896
R_rw_neg_2_9 node_in_9 node_sum_neg_2 33183.365650288775
R_rw_neg_2_10 node_in_10 node_sum_neg_2 51250.35024720255
R_rw_pos_2_11 node_in_11 node_sum_pos_2 35421.71984096429
R_rw_neg_2_12 node_in_12 node_sum_neg_2 48869.361850434645
R_rw_pos_2_13 node_in_13 node_sum_pos_2 49780.70748699382
R_rw_pos_2_14 node_in_14 node_sum_pos_2 199374.94554863984
R_rw_neg_2_15 node_in_15 node_sum_neg_2 52456.16326579107
R_rw_pos_2_16 node_in_16 node_sum_pos_2 525708.748428125
R_rw_neg_2_17 node_in_17 node_sum_neg_2 32304.058201624637
R_rw_neg_2_18 node_in_18 node_sum_neg_2 46851.92070993276
R_rw_neg_2_19 node_in_19 node_sum_neg_2 267429.9461454876
R_rw_neg_2_20 node_in_20 node_sum_neg_2 26361.32525822241
R_rw_neg_2_21 node_in_21 node_sum_neg_2 72207.82691864265
R_rw_neg_2_22 node_in_22 node_sum_neg_2 34001.13207294798
R_rw_neg_2_23 node_in_23 node_sum_neg_2 33785.817550073436
R_rw_neg_2_24 node_in_24 node_sum_neg_2 81948.59998136557
R_rw_pos_2_25 node_in_25 node_sum_pos_2 57324.69630038889
R_rw_pos_2_26 node_in_26 node_sum_pos_2 63099.508603435956
R_rw_pos_2_27 node_in_27 node_sum_pos_2 79282.4550544986
R_rw_pos_2_28 node_in_28 node_sum_pos_2 222574.10597804503
R_rw_pos_2_29 node_in_29 node_sum_pos_2 148188.31474176297
R_rw_neg_2_30 node_in_30 node_sum_neg_2 28091.82024011608
R_rw_pos_2_31 node_in_31 node_sum_pos_2 69611.48746946083
R_rbias_pos_2 node_bias node_sum_pos_2 63069.537621319985
X_opamp_sub_2 node_sub_pos_2 node_sub_neg_2 node_out_2 0 opamp_sat
R_rsub1_2 node_out_pos_2 node_sub_neg_2 10000.0
R_rsub2_2 node_sub_neg_2 node_out_2 10000.0
R_rsub3_2 node_out_neg_2 node_sub_pos_2 10000.0
R_rsub4_2 node_sub_pos_2 0 10000.0
X_opamp_pos_3 0 node_sum_pos_3 node_out_pos_3 0 opamp_sat
R_rf_pos_3 node_sum_pos_3 node_out_pos_3 10000.0
X_opamp_neg_3 0 node_sum_neg_3 node_out_neg_3 0 opamp_sat
R_rf_neg_3 node_sum_neg_3 node_out_neg_3 10000.0
R_rw_neg_3_0 node_in_0 node_sum_neg_3 141684.47130064998
R_rw_neg_3_1 node_in_1 node_sum_neg_3 27857.36191505814
R_rw_pos_3_2 node_in_2 node_sum_pos_3 1005379.8168944796
R_rw_pos_3_3 node_in_3 node_sum_pos_3 61547.15531037772
R_rw_neg_3_4 node_in_4 node_sum_neg_3 78458.64442772856
R_rw_pos_3_5 node_in_5 node_sum_pos_3 325376.2511437119
R_rw_neg_3_6 node_in_6 node_sum_neg_3 126372.93829587605
R_rw_pos_3_7 node_in_7 node_sum_pos_3 106988.72342723636
R_rw_neg_3_8 node_in_8 node_sum_neg_3 47909.17220958258
R_rw_pos_3_9 node_in_9 node_sum_pos_3 89717.43276259104
R_rw_pos_3_10 node_in_10 node_sum_pos_3 29009.00016114943
R_rw_pos_3_11 node_in_11 node_sum_pos_3 197817.42463204666
R_rw_pos_3_12 node_in_12 node_sum_pos_3 48665.83943249928
R_rw_pos_3_13 node_in_13 node_sum_pos_3 80782.97859022228
R_rw_pos_3_14 node_in_14 node_sum_pos_3 128483.39829886326
R_rw_pos_3_15 node_in_15 node_sum_pos_3 29146.16237870761
R_rw_neg_3_16 node_in_16 node_sum_neg_3 47836.69412410607
R_rw_neg_3_17 node_in_17 node_sum_neg_3 46380.74056043341
R_rw_neg_3_18 node_in_18 node_sum_neg_3 46431.16330333119
R_rw_neg_3_19 node_in_19 node_sum_neg_3 165078.6642915042
R_rw_neg_3_20 node_in_20 node_sum_neg_3 29761.85764677155
R_rw_pos_3_21 node_in_21 node_sum_pos_3 86229.1302634421
R_rw_neg_3_22 node_in_22 node_sum_neg_3 47456.040897036895
R_rw_pos_3_23 node_in_23 node_sum_pos_3 33697.93127052239
R_rw_pos_3_24 node_in_24 node_sum_pos_3 559013.084884421
R_rw_neg_3_25 node_in_25 node_sum_neg_3 51164.31785358432
R_rw_pos_3_26 node_in_26 node_sum_pos_3 42256.00381021992
R_rw_pos_3_27 node_in_27 node_sum_pos_3 47966.262514342416
R_rw_neg_3_28 node_in_28 node_sum_neg_3 104575.4586804632
R_rw_neg_3_29 node_in_29 node_sum_neg_3 460656.0976873794
R_rw_pos_3_30 node_in_30 node_sum_pos_3 124665.72774130615
R_rw_neg_3_31 node_in_31 node_sum_neg_3 102093.54488905982
R_rbias_pos_3 node_bias node_sum_pos_3 48862.99969288091
X_opamp_sub_3 node_sub_pos_3 node_sub_neg_3 node_out_3 0 opamp_sat
R_rsub1_3 node_out_pos_3 node_sub_neg_3 10000.0
R_rsub2_3 node_sub_neg_3 node_out_3 10000.0
R_rsub3_3 node_out_neg_3 node_sub_pos_3 10000.0
R_rsub4_3 node_sub_pos_3 0 10000.0
X_opamp_pos_4 0 node_sum_pos_4 node_out_pos_4 0 opamp_sat
R_rf_pos_4 node_sum_pos_4 node_out_pos_4 10000.0
X_opamp_neg_4 0 node_sum_neg_4 node_out_neg_4 0 opamp_sat
R_rf_neg_4 node_sum_neg_4 node_out_neg_4 10000.0
R_rw_pos_4_0 node_in_0 node_sum_pos_4 26291.28763829408
R_rw_neg_4_1 node_in_1 node_sum_neg_4 176315.899544214
R_rw_pos_4_2 node_in_2 node_sum_pos_4 529539.8563211191
R_rw_pos_4_3 node_in_3 node_sum_pos_4 223158.30882643294
R_rw_neg_4_4 node_in_4 node_sum_neg_4 79029.70464930049
R_rw_pos_4_5 node_in_5 node_sum_pos_4 346150.18870688457
R_rw_neg_4_6 node_in_6 node_sum_neg_4 27372.56084981269
R_rw_neg_4_7 node_in_7 node_sum_neg_4 82579.59341382448
R_rw_pos_4_8 node_in_8 node_sum_pos_4 57741.3715799747
R_rw_neg_4_9 node_in_9 node_sum_neg_4 1819547.9725463495
R_rw_neg_4_10 node_in_10 node_sum_neg_4 87738.1637598904
R_rw_neg_4_11 node_in_11 node_sum_neg_4 164467.42354576912
R_rw_neg_4_12 node_in_12 node_sum_neg_4 49341.20835584091
R_rw_pos_4_13 node_in_13 node_sum_pos_4 32869.35252009982
R_rw_neg_4_14 node_in_14 node_sum_neg_4 29141.671828389255
R_rw_neg_4_15 node_in_15 node_sum_neg_4 92744.2964263474
R_rw_neg_4_16 node_in_16 node_sum_neg_4 137770.44194040564
R_rw_pos_4_17 node_in_17 node_sum_pos_4 82288.81804047646
R_rw_pos_4_18 node_in_18 node_sum_pos_4 627380.5286011157
R_rw_pos_4_19 node_in_19 node_sum_pos_4 1142260.3086120966
R_rw_neg_4_20 node_in_20 node_sum_neg_4 82121.30847854148
R_rw_pos_4_21 node_in_21 node_sum_pos_4 71684.59951386956
R_rw_pos_4_22 node_in_22 node_sum_pos_4 64476.14812913203
R_rw_neg_4_23 node_in_23 node_sum_neg_4 380869.4239493653
R_rw_pos_4_24 node_in_24 node_sum_pos_4 54509.9117770857
R_rw_pos_4_25 node_in_25 node_sum_pos_4 78647.47031186458
R_rw_neg_4_26 node_in_26 node_sum_neg_4 35505.220165190156
R_rw_pos_4_27 node_in_27 node_sum_pos_4 58719.672473254795
R_rw_pos_4_28 node_in_28 node_sum_pos_4 39256.216930566974
R_rw_pos_4_29 node_in_29 node_sum_pos_4 91299.78829001554
R_rw_pos_4_30 node_in_30 node_sum_pos_4 163059.14930448725
R_rw_neg_4_31 node_in_31 node_sum_neg_4 29456.018755255624
R_rbias_neg_4 node_bias node_sum_neg_4 355839.7750074665
X_opamp_sub_4 node_sub_pos_4 node_sub_neg_4 node_out_4 0 opamp_sat
R_rsub1_4 node_out_pos_4 node_sub_neg_4 10000.0
R_rsub2_4 node_sub_neg_4 node_out_4 10000.0
R_rsub3_4 node_out_neg_4 node_sub_pos_4 10000.0
R_rsub4_4 node_sub_pos_4 0 10000.0
X_opamp_pos_5 0 node_sum_pos_5 node_out_pos_5 0 opamp_sat
R_rf_pos_5 node_sum_pos_5 node_out_pos_5 10000.0
X_opamp_neg_5 0 node_sum_neg_5 node_out_neg_5 0 opamp_sat
R_rf_neg_5 node_sum_neg_5 node_out_neg_5 10000.0
R_rw_pos_5_0 node_in_0 node_sum_pos_5 64151.64018187981
R_rw_neg_5_1 node_in_1 node_sum_neg_5 138190.59711456607
R_rw_pos_5_2 node_in_2 node_sum_pos_5 52623.750439224816
R_rw_pos_5_3 node_in_3 node_sum_pos_5 51349.800286373145
R_rw_neg_5_4 node_in_4 node_sum_neg_5 54884.61645095881
R_rw_pos_5_5 node_in_5 node_sum_pos_5 106001.37973137491
R_rw_neg_5_6 node_in_6 node_sum_neg_5 217802.1955196444
R_rw_pos_5_7 node_in_7 node_sum_pos_5 51979.80413715434
R_rw_pos_5_8 node_in_8 node_sum_pos_5 55576.537873389185
R_rw_neg_5_9 node_in_9 node_sum_neg_5 118088.59698130804
R_rw_pos_5_10 node_in_10 node_sum_pos_5 102787.53139028272
R_rw_pos_5_11 node_in_11 node_sum_pos_5 54841.28527724778
R_rw_pos_5_12 node_in_12 node_sum_pos_5 58506.470431718975
R_rw_neg_5_13 node_in_13 node_sum_neg_5 67355.92553486188
R_rw_neg_5_14 node_in_14 node_sum_neg_5 449076.42584053316
R_rw_neg_5_15 node_in_15 node_sum_neg_5 89047.67269284534
R_rw_neg_5_16 node_in_16 node_sum_neg_5 187221.41050188727
R_rw_pos_5_17 node_in_17 node_sum_pos_5 70546.72588164663
R_rw_pos_5_18 node_in_18 node_sum_pos_5 66722.84564878352
R_rw_pos_5_19 node_in_19 node_sum_pos_5 31345.109566347477
R_rw_pos_5_20 node_in_20 node_sum_pos_5 241633.92812376143
R_rw_pos_5_21 node_in_21 node_sum_pos_5 66432.79077484258
R_rw_pos_5_22 node_in_22 node_sum_pos_5 98363.42389952132
R_rw_neg_5_23 node_in_23 node_sum_neg_5 45957.75116171807
R_rw_neg_5_24 node_in_24 node_sum_neg_5 49292.683919324634
R_rw_pos_5_25 node_in_25 node_sum_pos_5 399932.2946250553
R_rw_pos_5_26 node_in_26 node_sum_pos_5 35270.37822510524
R_rw_neg_5_27 node_in_27 node_sum_neg_5 63174.114799034
R_rw_neg_5_28 node_in_28 node_sum_neg_5 47377.65031821786
R_rw_neg_5_29 node_in_29 node_sum_neg_5 108913.89375952262
R_rw_pos_5_30 node_in_30 node_sum_pos_5 37318.06316029233
R_rw_pos_5_31 node_in_31 node_sum_pos_5 33469.47642798285
R_rbias_neg_5 node_bias node_sum_neg_5 77484.539777225
X_opamp_sub_5 node_sub_pos_5 node_sub_neg_5 node_out_5 0 opamp_sat
R_rsub1_5 node_out_pos_5 node_sub_neg_5 10000.0
R_rsub2_5 node_sub_neg_5 node_out_5 10000.0
R_rsub3_5 node_out_neg_5 node_sub_pos_5 10000.0
R_rsub4_5 node_sub_pos_5 0 10000.0
X_opamp_pos_6 0 node_sum_pos_6 node_out_pos_6 0 opamp_sat
R_rf_pos_6 node_sum_pos_6 node_out_pos_6 10000.0
X_opamp_neg_6 0 node_sum_neg_6 node_out_neg_6 0 opamp_sat
R_rf_neg_6 node_sum_neg_6 node_out_neg_6 10000.0
R_rw_neg_6_0 node_in_0 node_sum_neg_6 32629.163546398424
R_rw_neg_6_1 node_in_1 node_sum_neg_6 38213.31533653683
R_rw_neg_6_2 node_in_2 node_sum_neg_6 284904.7451707648
R_rw_pos_6_3 node_in_3 node_sum_pos_6 526709.3197772652
R_rw_pos_6_4 node_in_4 node_sum_pos_6 194949.82230245127
R_rw_pos_6_5 node_in_5 node_sum_pos_6 42684.49637992962
R_rw_neg_6_6 node_in_6 node_sum_neg_6 140733.06369699707
R_rw_pos_6_7 node_in_7 node_sum_pos_6 47049.15215796331
R_rw_neg_6_8 node_in_8 node_sum_neg_6 37514.59242285201
R_rw_neg_6_9 node_in_9 node_sum_neg_6 40016.483898175975
R_rw_pos_6_10 node_in_10 node_sum_pos_6 30469.72571969884
R_rw_neg_6_11 node_in_11 node_sum_neg_6 31528.27675295441
R_rw_pos_6_12 node_in_12 node_sum_pos_6 956919.0421165223
R_rw_neg_6_13 node_in_13 node_sum_neg_6 306500.48709328397
R_rw_pos_6_14 node_in_14 node_sum_pos_6 88969.06625377745
R_rw_pos_6_15 node_in_15 node_sum_pos_6 38999.07309529801
R_rw_neg_6_16 node_in_16 node_sum_neg_6 780669.6819103989
R_rw_neg_6_17 node_in_17 node_sum_neg_6 57053.25613315882
R_rw_pos_6_18 node_in_18 node_sum_pos_6 32328.942027459303
R_rw_neg_6_19 node_in_19 node_sum_neg_6 33238.085200297646
R_rw_pos_6_20 node_in_20 node_sum_pos_6 86819.15668464487
R_rw_neg_6_21 node_in_21 node_sum_neg_6 454436.18757406465
R_rw_neg_6_22 node_in_22 node_sum_neg_6 31753.818992502547
R_rw_pos_6_23 node_in_23 node_sum_pos_6 76802.25299577918
R_rw_neg_6_24 node_in_24 node_sum_neg_6 226669.55117081653
R_rw_pos_6_25 node_in_25 node_sum_pos_6 394466.69827077707
R_rw_neg_6_26 node_in_26 node_sum_neg_6 41299.63301722466
R_rw_neg_6_27 node_in_27 node_sum_neg_6 34828.71001325496
R_rw_neg_6_28 node_in_28 node_sum_neg_6 27764.36750698982
R_rw_neg_6_29 node_in_29 node_sum_neg_6 236743.9831182561
R_rw_neg_6_30 node_in_30 node_sum_neg_6 78717.48039742032
R_rw_neg_6_31 node_in_31 node_sum_neg_6 37571.236797078185
R_rbias_neg_6 node_bias node_sum_neg_6 69887.93684214693
X_opamp_sub_6 node_sub_pos_6 node_sub_neg_6 node_out_6 0 opamp_sat
R_rsub1_6 node_out_pos_6 node_sub_neg_6 10000.0
R_rsub2_6 node_sub_neg_6 node_out_6 10000.0
R_rsub3_6 node_out_neg_6 node_sub_pos_6 10000.0
R_rsub4_6 node_sub_pos_6 0 10000.0
X_opamp_pos_7 0 node_sum_pos_7 node_out_pos_7 0 opamp_sat
R_rf_pos_7 node_sum_pos_7 node_out_pos_7 10000.0
X_opamp_neg_7 0 node_sum_neg_7 node_out_neg_7 0 opamp_sat
R_rf_neg_7 node_sum_neg_7 node_out_neg_7 10000.0
R_rw_neg_7_0 node_in_0 node_sum_neg_7 32858.605036309105
R_rw_pos_7_1 node_in_1 node_sum_pos_7 26186.094468510444
R_rw_neg_7_2 node_in_2 node_sum_neg_7 102240.60007762251
R_rw_neg_7_3 node_in_3 node_sum_neg_7 74192.0781507541
R_rw_pos_7_4 node_in_4 node_sum_pos_7 365591.21051772125
R_rw_neg_7_5 node_in_5 node_sum_neg_7 57286.928456967406
R_rw_pos_7_6 node_in_6 node_sum_pos_7 99828.20065733617
R_rw_neg_7_7 node_in_7 node_sum_neg_7 50104.54414321646
R_rw_neg_7_8 node_in_8 node_sum_neg_7 30339.931434482314
R_rw_neg_7_9 node_in_9 node_sum_neg_7 60274.45775646425
R_rw_neg_7_10 node_in_10 node_sum_neg_7 99303.47150007972
R_rw_neg_7_11 node_in_11 node_sum_neg_7 51211.893387105585
R_rw_neg_7_12 node_in_12 node_sum_neg_7 64288.34158944622
R_rw_pos_7_13 node_in_13 node_sum_pos_7 152536.76849556674
R_rw_pos_7_14 node_in_14 node_sum_pos_7 44207.712706530125
R_rw_pos_7_15 node_in_15 node_sum_pos_7 39596.249485493754
R_rw_pos_7_16 node_in_16 node_sum_pos_7 90368.7439777558
R_rw_neg_7_17 node_in_17 node_sum_neg_7 28035.82864926681
R_rw_pos_7_18 node_in_18 node_sum_pos_7 34468.96605424791
R_rw_neg_7_19 node_in_19 node_sum_neg_7 78978.57821324153
R_rw_pos_7_20 node_in_20 node_sum_pos_7 85815.50760169345
R_rw_pos_7_21 node_in_21 node_sum_pos_7 1737419.4686797315
R_rw_neg_7_22 node_in_22 node_sum_neg_7 41960.33552579954
R_rw_pos_7_23 node_in_23 node_sum_pos_7 38703.77139485078
R_rw_neg_7_24 node_in_24 node_sum_neg_7 138486.56243851085
R_rw_neg_7_25 node_in_25 node_sum_neg_7 29008.438395425383
R_rw_pos_7_26 node_in_26 node_sum_pos_7 35132.540025650174
R_rw_neg_7_27 node_in_27 node_sum_neg_7 29578.85363980324
R_rw_pos_7_28 node_in_28 node_sum_pos_7 119635.82033037588
R_rw_neg_7_29 node_in_29 node_sum_neg_7 95573.52777817337
R_rw_neg_7_30 node_in_30 node_sum_neg_7 32310.291900094944
R_rw_pos_7_31 node_in_31 node_sum_pos_7 46464.8254763106
R_rbias_pos_7 node_bias node_sum_pos_7 78668.39847138537
X_opamp_sub_7 node_sub_pos_7 node_sub_neg_7 node_out_7 0 opamp_sat
R_rsub1_7 node_out_pos_7 node_sub_neg_7 10000.0
R_rsub2_7 node_sub_neg_7 node_out_7 10000.0
R_rsub3_7 node_out_neg_7 node_sub_pos_7 10000.0
R_rsub4_7 node_sub_pos_7 0 10000.0
X_opamp_pos_8 0 node_sum_pos_8 node_out_pos_8 0 opamp_sat
R_rf_pos_8 node_sum_pos_8 node_out_pos_8 10000.0
X_opamp_neg_8 0 node_sum_neg_8 node_out_neg_8 0 opamp_sat
R_rf_neg_8 node_sum_neg_8 node_out_neg_8 10000.0
R_rw_neg_8_0 node_in_0 node_sum_neg_8 43292.25112356292
R_rw_neg_8_1 node_in_1 node_sum_neg_8 84639.46647099161
R_rw_neg_8_2 node_in_2 node_sum_neg_8 27336.1651652092
R_rw_neg_8_3 node_in_3 node_sum_neg_8 280224.5007464011
R_rw_pos_8_4 node_in_4 node_sum_pos_8 168941.14827549228
R_rw_neg_8_5 node_in_5 node_sum_neg_8 34390.74969003729
R_rw_pos_8_6 node_in_6 node_sum_pos_8 50252.5429595003
R_rw_pos_8_7 node_in_7 node_sum_pos_8 35289.76749796834
R_rw_pos_8_8 node_in_8 node_sum_pos_8 29259.984969940753
R_rw_neg_8_9 node_in_9 node_sum_neg_8 32511.05157083213
R_rw_neg_8_10 node_in_10 node_sum_neg_8 159532.6572038974
R_rw_pos_8_11 node_in_11 node_sum_pos_8 45905.00956558665
R_rw_neg_8_12 node_in_12 node_sum_neg_8 149263.57054246584
R_rw_neg_8_13 node_in_13 node_sum_neg_8 112238.19988354525
R_rw_neg_8_14 node_in_14 node_sum_neg_8 187026.09951456278
R_rw_neg_8_15 node_in_15 node_sum_neg_8 53706.369638445416
R_rw_pos_8_16 node_in_16 node_sum_pos_8 33491.17721359668
R_rw_pos_8_17 node_in_17 node_sum_pos_8 40892.212372556234
R_rw_neg_8_18 node_in_18 node_sum_neg_8 41680.189097480375
R_rw_pos_8_19 node_in_19 node_sum_pos_8 58001.1669572536
R_rw_pos_8_20 node_in_20 node_sum_pos_8 199310.15126860043
R_rw_pos_8_21 node_in_21 node_sum_pos_8 61638.45143513203
R_rw_neg_8_22 node_in_22 node_sum_neg_8 33007.556207247086
R_rw_neg_8_23 node_in_23 node_sum_neg_8 53806.04991964635
R_rw_pos_8_24 node_in_24 node_sum_pos_8 71704.23803688402
R_rw_neg_8_25 node_in_25 node_sum_neg_8 55228.17828691816
R_rw_pos_8_26 node_in_26 node_sum_pos_8 31861.78729468479
R_rw_neg_8_27 node_in_27 node_sum_neg_8 54178.83564958302
R_rw_pos_8_28 node_in_28 node_sum_pos_8 44541.466676896795
R_rw_pos_8_29 node_in_29 node_sum_pos_8 75923.67047324746
R_rw_neg_8_30 node_in_30 node_sum_neg_8 118011.7315600031
R_rw_neg_8_31 node_in_31 node_sum_neg_8 47437.084538542666
R_rbias_pos_8 node_bias node_sum_pos_8 61076.53052494852
X_opamp_sub_8 node_sub_pos_8 node_sub_neg_8 node_out_8 0 opamp_sat
R_rsub1_8 node_out_pos_8 node_sub_neg_8 10000.0
R_rsub2_8 node_sub_neg_8 node_out_8 10000.0
R_rsub3_8 node_out_neg_8 node_sub_pos_8 10000.0
R_rsub4_8 node_sub_pos_8 0 10000.0
X_opamp_pos_9 0 node_sum_pos_9 node_out_pos_9 0 opamp_sat
R_rf_pos_9 node_sum_pos_9 node_out_pos_9 10000.0
X_opamp_neg_9 0 node_sum_neg_9 node_out_neg_9 0 opamp_sat
R_rf_neg_9 node_sum_neg_9 node_out_neg_9 10000.0
R_rw_pos_9_0 node_in_0 node_sum_pos_9 362600.62695687637
R_rw_neg_9_1 node_in_1 node_sum_neg_9 33031.11996637275
R_rw_neg_9_2 node_in_2 node_sum_neg_9 10254356.035862586
R_rw_neg_9_3 node_in_3 node_sum_neg_9 434319.7988478293
R_rw_pos_9_4 node_in_4 node_sum_pos_9 150178.84026897483
R_rw_neg_9_5 node_in_5 node_sum_neg_9 49119.84904411931
R_rw_neg_9_6 node_in_6 node_sum_neg_9 66065.68680534362
R_rw_neg_9_7 node_in_7 node_sum_neg_9 34561.08227510222
R_rw_neg_9_8 node_in_8 node_sum_neg_9 334357.39304934896
R_rw_pos_9_9 node_in_9 node_sum_pos_9 644060.5581688734
R_rw_neg_9_10 node_in_10 node_sum_neg_9 31279.790647916063
R_rw_pos_9_11 node_in_11 node_sum_pos_9 744662.2474136704
R_rw_neg_9_12 node_in_12 node_sum_neg_9 39815.002755831
R_rw_neg_9_13 node_in_13 node_sum_neg_9 37750.952452795886
R_rw_pos_9_14 node_in_14 node_sum_pos_9 123419.65591062066
R_rw_neg_9_15 node_in_15 node_sum_neg_9 43559.48625289063
R_rw_pos_9_16 node_in_16 node_sum_pos_9 35808.88414725443
R_rw_pos_9_17 node_in_17 node_sum_pos_9 47890.37165298725
R_rw_neg_9_18 node_in_18 node_sum_neg_9 539488.727099377
R_rw_neg_9_19 node_in_19 node_sum_neg_9 38402.757033872134
R_rw_neg_9_20 node_in_20 node_sum_neg_9 27273.338504964962
R_rw_pos_9_21 node_in_21 node_sum_pos_9 94344.1728342525
R_rw_pos_9_22 node_in_22 node_sum_pos_9 2080550.466981776
R_rw_pos_9_23 node_in_23 node_sum_pos_9 49700.76021750801
R_rw_pos_9_24 node_in_24 node_sum_pos_9 30432.189757143296
R_rw_pos_9_25 node_in_25 node_sum_pos_9 67168.96006857335
R_rw_pos_9_26 node_in_26 node_sum_pos_9 50747.349992196076
R_rw_neg_9_27 node_in_27 node_sum_neg_9 3294304.511413721
R_rw_neg_9_28 node_in_28 node_sum_neg_9 70755.69755902945
R_rw_pos_9_29 node_in_29 node_sum_pos_9 219986.2551336322
R_rw_pos_9_30 node_in_30 node_sum_pos_9 43672.1657042814
R_rw_pos_9_31 node_in_31 node_sum_pos_9 81640.27343567758
R_rbias_pos_9 node_bias node_sum_pos_9 473749.7297565364
X_opamp_sub_9 node_sub_pos_9 node_sub_neg_9 node_out_9 0 opamp_sat
R_rsub1_9 node_out_pos_9 node_sub_neg_9 10000.0
R_rsub2_9 node_sub_neg_9 node_out_9 10000.0
R_rsub3_9 node_out_neg_9 node_sub_pos_9 10000.0
R_rsub4_9 node_sub_pos_9 0 10000.0

* Analysis Commands
.control
.op
print all
.endc
.end
